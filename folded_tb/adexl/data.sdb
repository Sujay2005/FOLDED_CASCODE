ADE simulation setup
Run mode: Single Run, Sweeps and Corners
Tests:
  FOLDED_CASCODE:folded_tb:1: FOLDED_CASCODE/folded_tb/schematic, simulator spectre
Corners:
  model folders: /home/buet/cadence/gpdk090_v4.6/models/spectre
  C0: temperature=-40 125; gpdk090.scs[FF FS SF SS]
Specs:
  FOLDED_CASCODE:folded_tb:1 / PMO: < 700m
  FOLDED_CASCODE:folded_tb:1 / PM1: < 350m
  FOLDED_CASCODE:folded_tb:1 / PM3: < 350m
  FOLDED_CASCODE:folded_tb:1 / PM4: < 350m
  FOLDED_CASCODE:folded_tb:1 / PM6: < 350m
  FOLDED_CASCODE:folded_tb:1 / NM2: > 200m
  FOLDED_CASCODE:folded_tb:1 / NM6: > 200m
  FOLDED_CASCODE:folded_tb:1 / NM3: > 300m
  FOLDED_CASCODE:folded_tb:1 / NM7: > 300m
