ADE simulation setup
Run mode: Single Run, Sweeps and Corners
Tests:
  FOLDED_CASCODE:folded_cascode:1: FOLDED_CASCODE/folded_cascode/schematic, simulator spectre
Corners:
  model folders: /home/buet/cadence/gpdk090_v4.6/models/spectre
  C0: temperature=-40 125; gpdk090.scs[FF FS SF SS]
Specs:
  FOLDED_CASCODE:folded_cascode:1 / (OP("/PM0" "vds") - OP("/PM0" "vdsat")): < 700m
  FOLDED_CASCODE:folded_cascode:1 / (OP("/PM1" "vds") - OP("/PM1" "vdsat")): < 350m
  FOLDED_CASCODE:folded_cascode:1 / (OP("/PM3" "vds") - OP("/PM3" "vdsat")): < 350m
  FOLDED_CASCODE:folded_cascode:1 / (OP("/PM4" "vds") - OP("/PM4" "vdsat")): < 350m
  FOLDED_CASCODE:folded_cascode:1 / (OP("/PM5" "vds") - OP("/PM5" "vdsat")): < 350m
  FOLDED_CASCODE:folded_cascode:1 / (OP("/PM6" "vds") - OP("/PM6" "vdsat")): < 350m
  FOLDED_CASCODE:folded_cascode:1 / (OP("/PM7" "vds") - OP("/PM7" "vdsat")): < 350m
  FOLDED_CASCODE:folded_cascode:1 / (OP("/NM3" "vds") - OP("/NM3" "vdsat")): > 300m
  FOLDED_CASCODE:folded_cascode:1 / (OP("/NM7" "vds") - OP("/NM7" "vdsat")): > 300m
